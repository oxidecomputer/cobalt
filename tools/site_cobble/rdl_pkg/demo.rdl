// Copyright 2022 Oxide Computer Company
// This is an example SystemRDL description of the sw-accesible registers

regfile a_reg_block {
    default regwidth = 8;
    
    reg {
        name = "Identification 0";
        default sw = r;
        
        field {
            desc = "0x1";
        } data[7:0] =  0x01;

    } ID0;
};

addrmap an_addr_block {
    name = "Example Address Map";
    desc = "An address map which is a useful example for code generation.";

    default regwidth = 8;
    default sw = rw;
    default hw = r;

    reg {
        name = "Status Register";
        field {
            desc = "First something bad bit";
        } SOMETHINGBAD[0:0] = 0;
        field {
            desc = "Second something bad bit";
        } ANOTHERBAD[2:2] = 0;
    } STATUS;

    reg {
        name = "Interrupt Control";
        field {
            desc = "These bits enable the interrupt and select the interrupt level";
        } INTLVL[1:0] = 0;
    } INTCTRL;

    a_reg_block r0;
    a_reg_block r1;

    reg output_regs_type {
        name = "Output Registers";
        default sw = r;

        field {
            desc = "Enables Voltage Regulator 1";
        } VR1_EN[1] = 0;
        field {
            desc = "Enables Voltage Regulator 0";
        } VR0_EN[1] = 0;
        field {
            desc = "Reset bit";
        } RST[1] = 0;
    };

    output_regs_type OUTPUT_0;
    OUTPUT_0->name = "Output block 0";
    output_regs_type OUTPUT_1;
    OUTPUT_1->name = "Output block 1";

    mem example_mem {
        mementries = 16;
        memwidth = 8;
    };

    external example_mem mem1;
    external example_mem mem2;

};